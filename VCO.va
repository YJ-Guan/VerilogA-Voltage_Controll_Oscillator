`include "constants.vams"
`include "disciplines.vams"

module VCO  (vin,vout);
	input vin; voltage vin;
	output vout; voltage vout;

/************* Internal Parameter ***********/
	real phase;
	real phase_ideal;
	real fc; 		// initial freq
	real fout;		// real output freq
	real f_ideal;	//freq without jitter
	real dT;
	real jitter = 10p;
	real gain; 		// vco voltage gain
	real vout_r;
	real vout_amp;	//	output voltage magnitude
	real ttol;
	real vtol;
	integer min_pts_update = 64;
	// minimum numver points per period
	integer seed;

/************* Behavioral Block ***********/
	analog begin
		@(initial_step)
		begin
			fc = 2G;
			gain = 200M;
			seed = 100;
			vout_amp = 1;
			ttol = 1n/2G;
			vtol = 1f;
		end

		f_ideal = fc + gain*V(vin);	// freq for input voltage
		$bound_step(1/(min_pts_update*fout)) ;

		phase = 2*`M_PI*idtmod (fout,0,1,0)-`M_PI;
		phase_ideal = 2*`M_PI*idtmod (f_ideal,0,1,0)-`M_PI;

		@(cross(phase + `M_PI/2,+1,ttol,vtol)
				or cross(phase - `M_PI/2,+1,ttol,vtol))
		begin 	// output square wave
			vout_r = (phase >= -`M_PI/2) && (phase <= `M_PI/2);
		end

		@(cross(phase_ideal + `M_PI/2,+1,ttol,vtol)
				or cross(phase_ideal - `M_PI/2,+1,ttol,vtol))
		begin 	// jitter calculation
			dT = 1.414 * jitter * $rdist_normal(seed,0,1);
			fout = f_ideal * (1 + dT*f_ideal);
		end

		V(vout) <+ transition ( vout_r ? vout_amp : 0 ,0,1p,1p);

	end

endmodule
